* ============================================================
* Circuit  : Rc Filter
* Generated: 2026-04-13 12:33
* Tool     : Python EDA System
* ============================================================

* RC Low Pass Filter
* Target fc = 1500.00 Hz  |  Achieved fc ≈ 1493.01 Hz
* Generated by Python EDA System

* Topology:  Vin --[R]-- Vout --[C]-- GND

Vin  in   0  AC 1  SIN(0 1 1500.00)
R1   in   out  1.3k
C1   out  0    82n
RL   out  0  10k

.OP
.AC DEC 100 15 1.5e+05
.END

* ── End of netlist ──────────────────────────────────────
