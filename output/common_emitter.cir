* ============================================================
* Circuit  : Common Emitter
* Generated: 2026-04-13 12:35
* Tool     : Python EDA System
* ============================================================

* Common-Emitter NPN Amplifier  (BC547)
* Target Av = 50.0 V/V  |  VCC = 12.0 V
* Achieved Av ≈ 49.81 V/V  |  IC ≈ 0.200 mA
* Generated by Python EDA System

* ── Power supply
VCC  vcc  0  DC 12.0

* ── AC input  (1 mV pk,  1000 Hz)
Vin  in   0  AC 1m  SIN(0 1m 1000)

* ── Input coupling cap
CC1  in   base  137n

* ── Voltage-divider bias
R1   vcc  base  430k
R2   base  0    150k

* ── BJT  (NPN BC547)
Q1   col  base  emit  BC547

* ── Collector resistor
RC   vcc  col   18k

* ── Emitter resistor + bypass cap
RE   emit  0    12k
CE   emit  0    6.42u

* ── Output coupling cap → load
CC2  col   out  100n
RL   out   0    10k

* ── BJT model  (BC547, simplified Gummel-Poon)
.MODEL BC547 NPN(IS=1e-14 BF=100 VAF=100
+              RB=10 RC=0.5 RE=0.1
+              CJC=4p CJE=10p TF=0.3n)

* ── Analyses
.OP
.AC DEC 100 10 100MEG
.TRAN 1n 5000000n

.END

* ── End of netlist ──────────────────────────────────────
