* ============================================================
* Circuit  : Voltage Divider Bias
* Generated: 2026-04-13 13:00
* Tool     : Python EDA System
* ============================================================

* Voltage-Divider-Bias CE Amplifier  (BC550 NPN)
* Target Av=100.0 V/V  |  VCC=12.0 V  |  S_max=10
* Achieved Av≈99.55 V/V  |  IC≈0.917 mA  |  S≈10.1
* Generated by Python EDA System

VCC  vcc  0  DC 12.0
Vin  in   0  AC 1m  SIN(0 1m 1000)
CC1  in   base  375n
R1   vcc  base  100k
R2   base  0    36k
Q1   col  base  emit  BC550
RC   vcc  col   3.9k
RE   emit  0    2.7k
CE   emit  0    34.6u
CC2  col   out  114n
RL   out   0    10k

* BC550 NPN (low-noise, high-hFE variant)
.MODEL BC550 NPN(IS=1e-14 BF=150 VAF=120
+              RB=8 RC=0.4 RE=0.1
+              CJC=3.5p CJE=9p TF=0.25n)

.OP
.AC DEC 100 10 100MEG
.END

* ── End of netlist ──────────────────────────────────────
